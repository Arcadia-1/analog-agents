// Fixture F1: RC ladder (Spectre flat — no subckt wrapping).
// See f1_rc_ladder.mrpp header for circuit + expected values.
simulator lang=spectre

r_1       (n1 n2) resistor r=10.0
r_2       (n2 n3) resistor r=20.0
r_3       (n3 n4) resistor r=30.0
ci_n2_gnd (n2 VSS) capacitor c=1e-15
